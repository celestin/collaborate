ADE simulation setup
Run mode: Single Run, Sweeps and Corners
Tests:
  sar_adc:SIM_sample_hold_3:1: sar_adc/SIM_sample_hold_3/schematic, simulator spectre
Global variables:
  delay = 0 (off)
  fall = 1p (off)
  period = 2u (off)
  pulse_width = 1u (off)
  rise = 1p (off)
  v1 = 1.2 (off)
  v2 = 0 (off)
  V_ac = 0 (off)
  v_dc = 1.2 (off)
  V_dc = 1.2 (off)
  frequency = 10k (off)
  v_amplitude = 600m (off)
  v_offset = 600m (off)
  vsin_dc = 600m (off)
  v_off = 0 (off)
  v_on = 1.2 (off)
  vbias_dc = 1.2 (off)
  res = {From/To}Decade:1K:1:1M{From/To}
