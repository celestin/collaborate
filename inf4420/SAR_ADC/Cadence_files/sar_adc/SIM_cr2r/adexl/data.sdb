ADE simulation setup
Run mode: Single Run, Sweeps and Corners
Tests:
  sar_adc:SIM_cr2r:1: sar_adc/SIM_cr2r/schematic, simulator spectre
Global variables:
  freq_in = 10k
  v_ref = {From/To}Linear:0:0.1:1.2{From/To}
  vin_ac = 600m
  vin_dc = 600m
