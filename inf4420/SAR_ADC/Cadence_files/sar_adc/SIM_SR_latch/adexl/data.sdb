ADE simulation setup
Run mode: Single Run, Sweeps and Corners
Tests:
  sar_adc:SIM_SR_latch:1: sar_adc/SIM_SR_latch/schematic, simulator spectre
Global variables:
  RESET_delay = 0 (off)
  RESET_period = 1 (off)
  RESET_width = 1u (off)
  SET_delay = 1u (off)
  SET_period = 4 (off)
  SET_width = 2u (off)
