ADE simulation setup
Run mode: Single Run, Sweeps and Corners
Tests:
  sar:SIM_dac_real_res:1: sar/SIM_dac_real_res/schematic, simulator spectre
Global variables:
  V0_p = 2u
  V0_w = 1u
  V1_p = 4u
  V1_w = 2u
  V2_p = 8u
  V2_w = 4u
  V3_p = 16u
  V3_w = 8u
  V4_p = 32u
  V4_w = 16u
  V5_p = 64u
  V5_w = 32u
  V6_p = 128u
  V6_w = 64u
  V7_p = 256u
  V7_w = 128u
  VDC = 1.2
  vref = 1.2
