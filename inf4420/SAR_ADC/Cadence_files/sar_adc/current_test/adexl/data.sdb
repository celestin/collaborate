ADE simulation setup
Run mode: Single Run, Sweeps and Corners
Tests:
  sar:current_test:1: sar/current_test/schematic, simulator spectre
Global variables:
  vbias = {From/To}Linear:0.65:0.05:0.9{From/To}
