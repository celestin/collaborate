ADE simulation setup
Run mode: Single Run, Sweeps and Corners
Tests:
  sar_adc:SIM_op_amp:1: sar_adc/SIM_op_amp/schematic, simulator spectre
Global variables:
  S_AC = 0.6
  S_AMPLITUDE = 0.6
  S_DC = 0.6
  S_FREQ = 10k
  VBIAS = {From/To}Auto:0.1:4:1.2{From/To}
  VDC = 5
Corners (all switched off):
  model folders: /projects/nanos/design_kit/TSMC90nmLPRF_616OA/models/spectre
  C2 (off): temperature=-25 0 25 100; crn90lp_2d5_lk_v1d2.scs[tt ss ff sf fs]
