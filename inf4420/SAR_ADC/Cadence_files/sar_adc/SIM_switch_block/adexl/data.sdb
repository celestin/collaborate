ADE simulation setup
Run mode: Single Run, Sweeps and Corners
Tests:
  sar_adc:SIM_switch_block:1: sar_adc/SIM_switch_block/schematic, simulator spectre
Global variables:
  period = 20u
  pulse_width = 10u
  V_off = 0
  v_on = 1.2
Corners (nominal off):
  model folders: /projects/nanos/design_kit/TSMC90nmLPRF_616OA/models/spectre
  C2: temperature=-25 0 25 100; crn90lp_2d5_lk_v1d2.scs[tt ss ff sf fs]
