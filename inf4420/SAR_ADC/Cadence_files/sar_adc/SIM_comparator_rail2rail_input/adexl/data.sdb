ADE simulation setup
Run mode: Single Run, Sweeps and Corners
Tests:
  sar:SIM_comparator_rail2rail_input:1: sar/SIM_comparator_rail2rail_input/schematic, simulator spectre
  sar:SIM_comparator_rail2rail_input:2: sar/SIM_comparator_rail2rail_input/schematic, simulator spectre
Global variables:
  vsweep = {From/To}Linear:0:0.1:1.2{From/To} (off)
  bias = {From/To}Linear:0.6:0.05:1.2{From/To}
  vin = 0.4
