ADE simulation setup
Run mode: Single Run, Sweeps and Corners
Tests:
  sar_adc:SIM_comparator_rail2rail_input_external_current:1: sar_adc/SIM_comparator_rail2rail_input_external_current/schematic, simulator spectre
Global variables:
  freq_in = 10k
  v_ref = {From/To}Linear:100m:100m:1100m{From/To} (off)
  vin_ac = 600m
  vin_dc = 600m
