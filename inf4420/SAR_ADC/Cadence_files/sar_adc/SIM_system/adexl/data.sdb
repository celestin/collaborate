ADE simulation setup
Run mode: Single Run, Sweeps and Corners
Tests:
  sar_adc:SIM_system:1: sar_adc/SIM_system/schematic, simulator spectre
Global variables:
  clk_period = 100n
  clk_width = 50n
  hold_delay = 0
  hold_period = 1.8u
  hold_width = 0.9u
  soc_delay = 0.1u
  soc_period = 0.9u
  soc_width = 0.8u
  freq_in = 10k
