ADE simulation setup
Run mode: Single Run, Sweeps and Corners
Tests:
  sar:SIM_system_5:1: sar/SIM_system_5/schematic, simulator spectre
Global variables:
  clk_period = 100n
  clk_width = 50n
  freq_in = 133k
  soc_delay = 2u
  soc_period = 3u
  soc_width = 0.5u
