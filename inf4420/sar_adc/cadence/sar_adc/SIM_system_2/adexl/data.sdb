ADE simulation setup
Run mode: Single Run, Sweeps and Corners
Tests:
  sar_adc:SIM_system_2:1: sar_adc/SIM_system_2/schematic, simulator spectre
Global variables:
  clk_period = 100n (off)
  clk_width = 50n (off)
  hold_delay = 0 (off)
  hold_period = 1.8u (off)
  hold_width = 0.9u (off)
  soc_delay = 0.1u (off)
  soc_period = 0.9u (off)
  soc_width = 0.8u (off)
  freq_in = 10k (off)
