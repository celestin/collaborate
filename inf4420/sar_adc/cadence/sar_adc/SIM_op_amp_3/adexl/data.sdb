ADE simulation setup
Run mode: Single Run, Sweeps and Corners
Tests:
  sar_adc:SIM_op_amp_3:1: sar_adc/SIM_op_amp_3/schematic, simulator spectre
Global variables:
  S_AC = 0.6
  S_AMPLITUDE = 0.6
  S_DC = 0.6
  S_FREQ = 10k
  v_bias = 1.2
