ADE simulation setup
Run mode: Single Run, Sweeps and Corners
Tests:
  sar_adc:SIM_system_3_u_sar_logic:1: sar_adc/SIM_system_3_u_sar_logic/schematic, simulator spectre
Global variables:
  clk_period = 100n (off)
  clk_width = 50n (off)
  freq_in = 133k (off)
  soc_delay = 2u (off)
  soc_period = 3u (off)
  soc_width = 0.5u (off)
  inital_phase = 120
