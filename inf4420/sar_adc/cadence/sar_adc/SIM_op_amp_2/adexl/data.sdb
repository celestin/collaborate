ADE simulation setup
Run mode: Single Run, Sweeps and Corners
Tests:
  sar_adc:SIM_op_amp_2:1: sar_adc/SIM_op_amp_2/schematic, simulator spectre
Global variables:
  S_AC = 1 (off)
  S_AMPLITUDE = 1.2 (off)
  S_DC = 0.6 (off)
  S_FREQ = 10k (off)
  v = 500m (off)
  v_bias1 = {From/To}Auto:0:4:200m{From/To}
  v_bias2 = {From/To}Auto:0:4:200m{From/To}
  v_neg = 500m (off)
