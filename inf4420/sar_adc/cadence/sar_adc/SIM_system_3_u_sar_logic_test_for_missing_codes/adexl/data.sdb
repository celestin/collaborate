ADE simulation setup
Run mode: Single Run, Sweeps and Corners
Tests:
  sar_adc:SIM_system_3_u_sar_logic_test_for_missing_codes:1: sar_adc/SIM_system_3_u_sar_logic_test_for_missing_codes/config, simulator spectre
Global variables:
  clk_period = 100n
  clk_width = 50n
  soc_delay = 1u
  soc_period = 2u
  soc_width = 100n
  sweep_voltage = {From/To}Linear:0:2.34375m:15m{From/To} (off)
