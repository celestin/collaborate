ADE simulation setup
Run mode: Single Run, Sweeps and Corners
Tests:
  sar_adc:SIM_sar_logic:2: sar_adc/SIM_sar_logic/schematic, simulator spectre
Global variables:
  clk_delay = 0
  clk_period = 2u
  clk_pulse_width = 1u
  soc_delay = 4u
  soc_period = 40u
  soc_pulse_width = 17u
  v_dc = 0.4
