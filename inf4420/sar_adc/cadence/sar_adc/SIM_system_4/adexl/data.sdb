ADE simulation setup
Run mode: Single Run, Sweeps and Corners
Tests:
  sar:SIM_system_4:1: sar/SIM_system_4/schematic, simulator spectre
Global variables:
  clk_period = 1u
  clk_width = 0.5u
  freq_in = 350k
  soc_delay = 35u
  soc_period = 80u
  soc_width = 4u
  reset_d = 34u
  reset_p = 100u
  reset_w = 2u
