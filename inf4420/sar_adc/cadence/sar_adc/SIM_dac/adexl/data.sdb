ADE simulation setup
Run mode: Single Run, Sweeps and Corners
Tests:
  sar_adc:SIM_dac:1: sar_adc/SIM_dac/schematic, simulator spectre
Global variables:
  V0_dc = 1.2
  V1_dc = 1.2
  V2_dc = 1.2
  V3_dc = 1.2
  V4_dc = 1.2
  V5_dc = 1.2
  V6_dc = 1.2
  V7_dc = 1.2
