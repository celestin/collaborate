ADE simulation setup
Run mode: Single Run, Sweeps and Corners
Tests:
  sar_adc:cap_test:1: sar_adc/cap_test/schematic, simulator spectre
