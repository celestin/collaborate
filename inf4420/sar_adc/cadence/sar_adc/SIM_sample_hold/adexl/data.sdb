ADE simulation setup
Run mode: Single Run, Sweeps and Corners
Tests:
  sar_adc:SIM_sample_hold:1: sar_adc/SIM_sample_hold/schematic, simulator spectre
Global variables:
  delay = 0
  fall = 1p
  period = 2u
  pulse_width = 1u
  rise = 1p
  v1 = 1.2 (off)
  v2 = 0 (off)
  V_ac = 0
  v_dc = 1.2 (off)
  V_dc = 1.2
  frequency = 10k
  v_amplitude = 600m
  v_offset = 600m
  vsin_dc = 600m
  v_off = 0
  v_on = 1.2
  vbias_dc = 1.2
