ADE simulation setup
Run mode: Single Run, Sweeps and Corners
Tests:
  sar:SIM_clk_gen:1: sar/SIM_clk_gen/schematic, simulator spectre
Global variables:
  periode = 100n
  width = 50n
Corners:
  model folders: /projects/nanos/design_kit/TSMC90nmLPRF_616OA/models/spectre
  C2 (off): temperature=-25 0 25 100; crn90lp_2d5_lk_v1d2.scs[tt ss ff sf fs]
