ADE simulation setup
Run mode: Single Run, Sweeps and Corners
Tests:
  sar:SIM_clk_gen_current_starved:1: sar/SIM_clk_gen_current_starved/schematic, simulator spectre
Global variables:
  nbias = 1.1
  pbias = 0.1
  period = 100n
  tr_time = 10n
  width = 50n
