ADE simulation setup
Run mode: Single Run, Sweeps and Corners
Tests:
  sar:SIM_schmitt_trigger:1: sar/SIM_schmitt_trigger/schematic, simulator spectre
Global variables:
  period = 5u
  tr_time = 1u
  width = 2.5u
