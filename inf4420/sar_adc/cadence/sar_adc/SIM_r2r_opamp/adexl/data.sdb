ADE simulation setup
Run mode: Single Run, Sweeps and Corners
Tests:
  sar:SIM_r2r_opamp:1: sar/SIM_r2r_opamp/schematic, simulator spectre
Global variables:
  freq_in = {From/To}Octave:32k:1:128k{From/To}
