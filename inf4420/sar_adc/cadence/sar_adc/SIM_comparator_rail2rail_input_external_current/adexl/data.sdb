ADE simulation setup
Run mode: Single Run, Sweeps and Corners
Tests:
  sar:SIM_comparator_rail2rail_input_external_current:1: sar/SIM_comparator_rail2rail_input_external_current/schematic, simulator spectre
Global variables:
  vin_ac = 0.6
  vin_dc = 0.6
  freq_in = {Inclusion List}8M{Inclusion List}
  v_ref = {From/To}Linear:0.4:0.2:0.8{From/To} (off)
  vbias_current = {From/To}Linear:0.8:0.05:1.2{From/To} (off)
Corners (nominal off):
  model folders: /projects/nanos/design_kit/TSMC90nmLPRF_616OA/models/spectre
  C2: temperature=-25 0 25 100; crn90lp_2d5_lk_v1d2.scs[tt ss ff sf fs]
