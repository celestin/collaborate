ADE simulation setup
Run mode: Single Run, Sweeps and Corners
Tests:
  sar_adc:SIM_dac_2_simple_feedback:1: sar_adc/SIM_dac_2_simple_feedback/schematic, simulator spectre
Global variables:
  B0 = 1.2
  B1 = 1.2
  B2 = 1.2
  B3 = 1.2
  B4 = 1.2
  B5 = 1.2
  B6 = 1.2
  B7 = 1.2
  delay = 0
  fall = 10n
  period = 10u
  pulse_width = 5u
  rise = 10n
  v_dc = 1.2
