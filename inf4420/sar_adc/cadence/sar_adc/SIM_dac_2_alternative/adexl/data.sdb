ADE simulation setup
Run mode: Single Run, Sweeps and Corners
Tests:
  sar_adc:SIM_dac_2:1: sar_adc/SIM_dac_2/schematic, simulator spectre
Global variables:
  B0 = 1.2 (off)
  B1 = 1.2 (off)
  B2 = 1.2 (off)
  B3 = 1.2 (off)
  B4 = 1.2 (off)
  B5 = 0 (off)
  B6 = 1.2 (off)
  B7 = 1.2 (off)
  delay = 0
  fall = 1p
  period = 1m
  pulse_width = 500u
  rise = 1p
  v_dc = 1.2
